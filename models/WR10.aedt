# Ansys Electronics Desktop project, version 2020.1
project variables:
  $w = 2.54mm
  $t = 1.27mm
  $l = 5mm
materials:
  vacuum: permittivity=1

design HFSSDesign1 (HFSS, DrivenModal, model units mm)
geometry:
  Box1 [vacuum] = box(corner=(-$l/2, -$w/2, -$t/2), size=($l, $w, $t))
boundaries and excitations:
  1: Wave Port Faces=Box1.face(+x) NumModes=1 Modes{Mode1{IntLine{middle of Box1.edge(5 of 12) -> middle of Box1.edge(1 of 12)} CharImp=Zpi}}
  2: Wave Port Faces=Box1.face(-x) NumModes=1 Modes{Mode1{IntLine{middle of Box1.edge(7 of 12) -> middle of Box1.edge(3 of 12)} CharImp=Zpi}}
setups:
  Setup1: HfssDriven Frequency=100GHz MaxDeltaS=0.02 MaximumPasses=6 MinimumPasses=1 MinimumConvergedPasses=1 PercentRefinement=30 BasisOrder=1 PortAccuracy=2
    sweep Sweep: 50GHz to 110GHz, 401 points; Type=Interpolating InterpTolerance=0.5 InterpMaxSolns=250 InterpUsePortImped=false PassivityErrorTolerance=0.0001
source amplitudes:
  1:1: 1W 0deg
  2:1: 0W 0deg
reports:
  S Parameter Plot 1: dB(S(1,1)), dB(S(2,1)) vs Freq on Setup1 : Sweep
